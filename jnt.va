//JNT analytic model

//

//Based on Doria, Renan T thesis

// Centro Universitario FEI

//

//Verilog model by Moreira, Claudio V

//Revision 1.1.1 July/2017

`include "discipline.vams"

`include "constants.vams"

`define NMOS 1

`define PMOS -1

module jnt(d, g, s, b);

    inout d, g, s, b;

    electrical d, g, s, b;

    parameter integer type = `NMOS from [-1 : 1] exclude 0;

    parameter integer level  =    1   from [1 : 1];

    parameter real eox = 3.9*8.85e-14;					//F/cm

    parameter real esi = 11.8*8.85e-14;					//F/cm

    parameter real m0 = 9.1095e-31;						//kg

    parameter real tnom = 26.85 from [-273.15:inf];		//Ambient temperature in C

    parameter real H = 10.0E-7;

    parameter real W=50.0E-7;

    parameter real Ndop=5.0E18;

    parameter real tox = 2.0E-7;

    parameter real tbox = 100.0E-7;

    parameter real L = 100.0E-7;

    parameter real ml = 0.9163;

    parameter real vsat = 1.0E7;

    //Adjustments

    parameter real Cox_crnr = 2.5; // Corner capacitance

    parameter real d_FiMS = 0.0;  //FiMS adjust

    parameter real Qox = 0.0;   //Oxide fixed equivalent charge

    parameter real cte_a1 = 10.156;

    parameter real cte_a2 = 8.875;

    parameter real theta = 0.125;

    //Density of States

    analog function real Nx;

        input T, mdx;

        real T, mdx;

        begin

            Nx =  2.0*pow((2.0 * `M_PI * mdx * m0 *`P_K * T)/(`P_H*`P_H),(1.5))*2.0E-6;

        end

    endfunction //Nx

    //Temperature in Kelvin

    real T;

    //Effective masses

    real mt, mde, mdh, mce;

    //Silicon parameters

    real Nv, Nc, Nd;

    real Eg;

    real ni, n;

    real fit, FiBS, Vsub2, xdepl, phisB;

    //Capacitances

    real Cox, Cbox, Wox;

    //Potencial de Fermi

    real fif, FiMS;

    //????

    real De, Ypot, Qsi, Vfb;

    //Current calculation by charges

    real Vds, Vgs, Vs, Vd, Vth, Vsub;

    real cte, cte2, Vg2, Vg3, phisdep, phisacc, phis, Qcs;

    real lambda1, lambda2, lambda, U, xmin, phimin;

    real cteL, cte2L, Vg22, Vg33, phisdepL, phisaccL, phisL, Qcd;

    real mu, Id;

    analog begin

        begin : evaluate

            Vds = V(d, s);

            Vgs = V(g, s);

            Vd = Vds;

            Vs = 0.0;

            Vsub = V(b, s);

            //Celcius to Kelvin

            T = tnom + `P_CELSIUS0;

            //Masses

            mt = 0.1913-(4.042E-5)*T +(1.392E-6)*T*T-(4.326E-9)*T*T*T+(4.42E-12)*T*T*T*T;

            mde = pow((6.0*sqrt(ml*(mt*mt))), (2.0/3.0));

            mdh =  0.5906 - 2.45E-4*T + 1.1504E-5*T*T - 4.115E-8*T*T*T + 4.502E-11*T*T*T*T;

            mce = 1.0/((1.0/3.0)*(1.0/ml+  2.0/mt ));

            Nd=Ndop;

            //Density of States

            Nv = Nx(T, mdh);

            Nc = Nx(T, mde);

            //Energy gap

            Eg = 1.1696 - 4.73e-4*(T*T)/(636.0+T);

            //Thermical Potential

            fit = `P_K*T/`P_Q;

            //Intrinsic Concentration

            ni =  sqrt(Nc*Nv) * exp(-Eg/(2.0*fit));

            //Fermi Potential

            fif = fit *ln (Nd/ni);

            FiMS =  fif + (Eg/2.0) + d_FiMS;

            //Capacitance

            Wox = 2.0*H+W;

            Cox =  eox*(Wox/tox + Cox_crnr);

            Cbox = eox*(W+0.0)/tbox;

            //Substract Influence

            FiBS = fit * ln(Nd*1.0E15/(ni*ni));

            Vsub2=(FiBS+10.0)*(1.0+ln(1+limexp(5.0*(-1.0+(Vsub+10.0)/(FiBS+10.0)))) /(ln(1.0+limexp(5.0))))-10.0;

            xdepl = (-esi)/(eox/tbox) + sqrt((esi/(eox/tbox))*(esi/(eox/tbox))+2.0*esi*(Vsub2-Vsub)/(`P_Q*Nd));

            phisB = xdepl * xdepl * `P_Q * Nd /(2.0*esi);

            //

            Vfb = FiMS - (Qox/Cox);

            De = `P_Q*Nd*esi*(Wox*Wox);

            Ypot = De/(Cox*Cox);

            Qsi = `P_Q*Nd*W*H -Cbox*(FiBS-Vsub+phisB);

            //Threshold Voltage

            Vth = Vfb - Qsi/Cox - (1.0/(`P_Q*Nd))*((Qsi*Qsi)/(esi*Wox*Wox));

            //Mobility

            mu = 100.0;

            mu = mu/(1.0+theta*max(((Vgs-Vfb)*tanh(4.0*(Vgs-Vfb))),0.0));

            //DIBL

            cte = 18.0-cte_a1/(1.0+limexp(-cte_a2 *(Vgs-Vth-Vs)));

            cte2 = (Vth+2.0)/(2.0*1.0*fit);

            cte2 = cte2-0.5*cte2/(1.0+1.0*exp(-3.0*(Vgs-Vth-Vs)));

            Vg2=Vfb*(1.0-ln(1.0+ limexp(cte*(1.0- ((Vgs-Vs)/Vfb))))/ln(1.0+limexp(cte)));

            Vg3 = Vth+(Vth+2.0)*(ln(1.0+limexp(cte2*(-1.0+((Vg2+2.0)/(Vth+2.0)))))/ln(1.0+limexp(cte2)) );

            phisdep = Vg2 - Vfb + Vs - Ypot/2.0 + sqrt( (Ypot/2.0)*(Ypot/2.0) - Ypot*(Vg3-Vfb));

            cteL = 18.0-cte_a1/(1.0+limexp(-cte_a2 *(Vgs-Vth-Vd)));

            cte2L = (Vth+2.0)/(2.0*1.0*fit);

            cte2L = cte2L-0.5*cte2L/(1.0+1.0*exp(-3.0*(Vgs-Vth-Vd)));

            Vg22=Vfb*(1.0-ln(1.0+ limexp(cteL*(1.0- ((Vgs-Vd)/Vfb))))/ln(1.0+limexp(cteL)));

            Vg33 = Vth+(Vth+2.0)*(ln(1.0+limexp(cte2L*(-1.0+((Vg22+2.0)/(Vth+2.0)))))/ln(1.0+limexp(cte2L)));

            phisdepL = Vg22 - Vfb + Vd - Ypot/2.0 + sqrt( (Ypot/2.0)*(Ypot/2.0) - Ypot*(Vg33-Vfb));

            lambda1 = sqrt((esi*W*tox/(4.0*eox))*(1.0+eox*W/(2.0*esi*tox)));

            lambda2 = sqrt((esi*H*tox/(4.0*eox))*(1.0+eox*H/(2.0*esi*tox)));

            lambda = 1.0/(sqrt((1.0/lambda1)*(1.0/lambda1)+(0.5/lambda2)*(0.5/lambda2)));

            U = phisdepL-Vd; //V = phisdep - Vs

            xmin = (lambda/2)*ln(abs((U*limexp(L/lambda)-phisdep)/(phisdep-U*limexp(-L/lambda))));

            phimin = ((phisdep-Vs)*sinh(xmin/lambda)+U*sinh((L-xmin)/lambda))/(sinh(L/lambda));

            Vgs = Vgs-phimin;

            //Qcs

            cte = 18.0-cte_a1/(1.0+limexp(-cte_a2 *(Vgs-Vth-Vs)));

            cte2 = (Vth+2.0)/(2.0*1.0*fit);

            cte2 = cte2-0.5*cte2/(1.0+1.0*exp(-3.0*(Vgs-Vth-Vs)));

            Vg2=Vfb*(1.0-ln(1.0+ limexp(cte*(1.0- ((Vgs-Vs)/Vfb))))/ln(1.0+limexp(cte)));

            Vg3 = Vth+(Vth+2.0)*(ln(1.0+limexp(cte2*(-1.0+((Vg2+2.0)/(Vth+2.0)))))/ln(1.0+limexp(cte2)) );

            phisdep = Vg2 - Vfb + Vs - Ypot/2.0 + sqrt( (Ypot/2.0)*(Ypot/2.0) - Ypot*(Vg3-Vfb) );

            phisacc = fit*ln(1.0+ ((Vgs-Vg2-Vs)*(Vgs-Vg2-Vs)/(Ypot*fit)));

            phis = phisacc + phisdep;

            Qcs = (Vgs - Vfb - phis)*Cox + Qsi;

            //Qcd

            cteL = 18.0-cte_a1/(1.0+limexp(-cte_a2 *(Vgs-Vth-Vd)));

            cte2L = (Vth+2.0)/(2.0*1.0*fit);

            cte2L = cte2L-0.5*cte2L/(1.0+1.0*exp(-3.0*(Vgs-Vth-Vd)));

            Vg22=Vfb*(1.0-ln(1.0+ limexp(cteL*(1.0- ((Vgs-Vd)/Vfb))))/ln(1.0+limexp(cteL)));

            Vg33 = Vth+(Vth+2.0)*(ln(1.0+limexp(cte2L*(-1.0+((Vg22+2.0)/(Vth+2.0)))))/ln(1.0+limexp(cte2L)));

            phisdepL = Vg22 - Vfb + Vd - Ypot/2.0 + sqrt( (Ypot/2.0)*(Ypot/2.0) - Ypot*(Vg33-Vfb));

            phisaccL = fit*ln(1.0+ ((Vgs-Vg22-Vd)*(Vgs-Vg22-Vd)/(Ypot*fit)));

            phisL = phisaccL + phisdepL;

            Qcd = (Vgs - Vfb - phisL)*Cox + Qsi;

            //Mobility Degradation

            //mu = mu / (1.0 + ((Vds * mu)/(L * vsat)));

            //Currents

            Id = (mu /L)*((Qcs*Qcs - Qcd*Qcd)/(2.0 * Cox));

            I(d,s) <+ Id;

            I(g,s) <+ Vth;

            I(b,s) <+ 0.0;

        end //evaluate

    end //analog begin

endmodule
